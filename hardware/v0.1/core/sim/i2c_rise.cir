* deck: i2c-rise SDA SCL
* The rise time of 1 I2C line. The last device lets the line go at 1 us; its pull-up then charges the
* bus capacitance. 1 line stands for the bus when every line has the same pull-up and capacitance.
* UM10204 Rev. 7.0 (NXP, 1 October 2021):
*   Table 11, page 44: tr is measured from 0.3 VDD to 0.7 VDD; Fast-mode 20 to 300 ns.
*   Section 7.1, page 50: this circuit gives tr = 0.8473 x Rp x Cb.
*   Table 10, page 43: a device sinks 3 mA at VOL 0.4 V at the least (VDD over 2 V).
* The pull-ups go to 3V0, the regulator U4's 3.0 V.
VDD vdd 0 DC 3.0
* R1 pulls SDA up; R2, of the same value, pulls SCL up, and this line stands for both.
* 100 ppm/K: a thick-film 0402 chip resistor's coefficient at the most (Yageo RC0402 series).
R1 vdd sda 4.7k tc1=100u
* Cb is 400 pF at most in Standard- and Fast-mode (Table 11, page 44).
* The Core alone: U1's and U2's pins at 10 pF each, 5 pF for 60 mm of 0.15 mm track and the port's pad.
* A module adds 2 device pins and its own tracks, 25 pF: 50 pF with the Health module on.
CBUS sda 0 50p
* SOD is the device that pulls the line low, at its limit: 0.4 V at 3 mA is 0.4 / 0.003 = 133.3 ohm.
* For VDD at 2 V or under, Table 10 gives VOL2 0.2 VDD at 2 mA: set Ron to 0.2 x VDD / 0.002.
SOD sda 0 ctl 0 SWOD
.model SWOD SW(Ron=133.3 Roff=1G Vt=0.5 Vh=0.1)
* Low until 1 us, released until 20 us, then low again.
VCTL ctl 0 PWL(0 1 1u 1 1.001u 0 20u 0 20.001u 1)
.tran 1n 24u
.control
run
let vtop = vecmax(v(vdd))
let v30 = 0.3 * vtop
let v70 = 0.7 * vtop
meas tran t30 when v(sda)=$&v30 rise=1
meas tran t70 when v(sda)=$&v70 rise=1
let tr = t70 - t30
meas tran ilow find i(vdd) at=23u
let isink = abs(ilow)
* The least current a device sinks (Table 10, page 43): 3 mA for VDD over 2 V, 2 mA at 2 V or below.
let iol = 0.003
if vtop le 2
  let iol = 0.002
end
let isink_share = isink / iol
print tr isink isink_share
.endc
.end
